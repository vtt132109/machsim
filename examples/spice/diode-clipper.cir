Diode clipper
* Two anti-parallel 1N4148 diodes clip a 5 V, 1 kHz sine to about +/-0.7 V.
* Hai diode song song nguoc chieu xen tin hieu sin 5 V dinh con khoang +/-0.7 V.
VIN in 0 SIN(0 5 1k) AC 1
R1 in out 1k
D1 out 0 D1N4148
D2 0 out D1N4148
* published 1N4148 model parameters
.model D1N4148 D(IS=2.52n RS=0.568 N=1.752 CJO=4p M=0.4 TT=20n BV=100 IBV=100u)
.tran 5u 3m
.end
